ADE simulation setup
Run mode: Single Run, Sweeps and Corners
Tests:
  CNFET:STI_design_2013IEEE:1: CNFET/STI_design_2013IEEE/schematic, simulator spectre
    Outputs: /vin; /vout
